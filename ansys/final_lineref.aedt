# Ansys Electronics Desktop project, version 2019.3
materials:
  copper: permeability=0.999991 conductivity=58000000
  FR4_epoxy: permittivity=4.4 dielectric_loss_tangent=0.02
  air: permittivity=1.0006 permeability=1.0000004
  vacuum: permittivity=1
  pec: conductivity=1e+30

design final1 (HFSS 3D Layout)
ports:
  Port1, Port2: Properties{Impedance=50ohm Magnitude=1V Phase=0deg Renormalize_Impedence="50ohm + 0i ohm" Renormalize Deembed_Distance=0mm Deembed Layer_Alignment=Upper Horizontal_Extent_Factor=5 Vertical_Extent_Factor=3 PEC_Launch_Width=0mm} Type=EdgePort CircuitPort
setups:
  HFSS Setup 1: SolveSetupType=HFSS PercentRefinementPerPass=30 MinNumberOfPasses=1 MinNumberOfConvergedPasses=1 Frequency=10GHz MeshSizeFactor=1.5 ViaNumSides=6 ViaMaterial=copper Style25DVia=Mesh
    sweep Sweep 1: LIN 0GHz 10GHz 0.1GHz; FastSweep SAbsError=0.005 ZoPercentError=1 PassivityTolerance=0.0001 UseQ3DForDC MaxSolutions=250 InterpUseSMatrix InterpUsePortImpedance InterpUseFullBasis MagMinThreshold=0.01

design final2 (HFSS 3D Layout)
ports:
  Port1, Port2: Properties{Impedance=50ohm Magnitude=1V Phase=0deg Renormalize_Impedence="50ohm + 0i ohm" Renormalize Deembed_Distance=0mm Deembed Layer_Alignment=Upper Horizontal_Extent_Factor=5 Vertical_Extent_Factor=3 PEC_Launch_Width=0mm} Type=EdgePort CircuitPort
setups:
  HFSS Setup 1: SolveSetupType=HFSS PercentRefinementPerPass=30 MinNumberOfPasses=1 MinNumberOfConvergedPasses=1 Frequency=10GHz MeshSizeFactor=1.5 ViaNumSides=6 ViaMaterial=copper Style25DVia=Mesh
    sweep Sweep 1: LIN 0GHz 10GHz 0.1GHz; FastSweep SAbsError=0.005 ZoPercentError=1 PassivityTolerance=0.0001 UseQ3DForDC MaxSolutions=250 InterpUseSMatrix InterpUsePortImpedance InterpUseFullBasis MagMinThreshold=0.01

design final3 (HFSS 3D Layout)
ports:
  Port1, Port2: Properties{Impedance=50ohm Magnitude=1V Phase=0deg Renormalize_Impedence="50ohm + 0i ohm" Renormalize Deembed_Distance=0mm Deembed Layer_Alignment=Upper Horizontal_Extent_Factor=5 Vertical_Extent_Factor=3 PEC_Launch_Width=0mm} Type=EdgePort CircuitPort
setups:
  HFSS Setup 1: SolveSetupType=HFSS PercentRefinementPerPass=30 MinNumberOfPasses=1 MinNumberOfConvergedPasses=1 Frequency=10GHz MeshSizeFactor=1.5 ViaNumSides=6 ViaMaterial=copper Style25DVia=Mesh
    sweep Sweep 1: LIN 0GHz 10GHz 0.1GHz; FastSweep SAbsError=0.005 ZoPercentError=1 PassivityTolerance=0.0001 UseQ3DForDC MaxSolutions=250 InterpUseSMatrix InterpUsePortImpedance InterpUseFullBasis MagMinThreshold=0.01

design final4 (HFSS 3D Layout)
ports:
  Port1, Port2: Properties{Impedance=50ohm Magnitude=1V Phase=0deg Renormalize_Impedence="50ohm + 0i ohm" Renormalize Deembed_Distance=0mm Deembed Layer_Alignment=Upper Horizontal_Extent_Factor=5 Vertical_Extent_Factor=3 PEC_Launch_Width=0mm} Type=EdgePort CircuitPort
setups:
  HFSS Setup 1: SolveSetupType=HFSS PercentRefinementPerPass=30 MinNumberOfPasses=1 MinNumberOfConvergedPasses=1 Frequency=10GHz MeshSizeFactor=1.5 ViaNumSides=6 ViaMaterial=copper Style25DVia=Mesh
    sweep Sweep 1: LIN 0GHz 10GHz 0.1GHz; FastSweep SAbsError=0.005 ZoPercentError=1 PassivityTolerance=0.0001 UseQ3DForDC MaxSolutions=250 InterpUseSMatrix InterpUsePortImpedance InterpUseFullBasis MagMinThreshold=0.01

design final5 (HFSS 3D Layout)
ports:
  Port1, Port2: Properties{Impedance=50ohm Magnitude=1V Phase=0deg Renormalize_Impedence="50ohm + 0i ohm" Renormalize Deembed_Distance=0mm Deembed Layer_Alignment=Upper Horizontal_Extent_Factor=5 Vertical_Extent_Factor=3 PEC_Launch_Width=0mm} Type=EdgePort CircuitPort
setups:
  HFSS Setup 1: SolveSetupType=HFSS PercentRefinementPerPass=30 MinNumberOfPasses=1 MinNumberOfConvergedPasses=1 Frequency=10GHz MeshSizeFactor=1.5 ViaNumSides=6 ViaMaterial=copper Style25DVia=Mesh
    sweep Sweep 1: LIN 0GHz 10GHz 0.1GHz; FastSweep SAbsError=0.005 ZoPercentError=1 PassivityTolerance=0.0001 UseQ3DForDC MaxSolutions=250 InterpUseSMatrix InterpUsePortImpedance InterpUseFullBasis MagMinThreshold=0.01

design final6 (HFSS 3D Layout)
ports:
  Port1, Port2: Properties{Impedance=50ohm Magnitude=1V Phase=0deg Renormalize_Impedence="50ohm + 0i ohm" Renormalize Deembed_Distance=0mm Deembed Layer_Alignment=Upper Horizontal_Extent_Factor=5 Vertical_Extent_Factor=3 PEC_Launch_Width=0mm} Type=EdgePort CircuitPort
setups:
  HFSS Setup 1: SolveSetupType=HFSS PercentRefinementPerPass=30 MinNumberOfPasses=1 MinNumberOfConvergedPasses=1 Frequency=10GHz MeshSizeFactor=1.5 ViaNumSides=6 ViaMaterial=copper Style25DVia=Mesh
    sweep Sweep 1: LIN 0GHz 10GHz 0.1GHz; FastSweep SAbsError=0.005 ZoPercentError=1 PassivityTolerance=0.0001 UseQ3DForDC MaxSolutions=250 InterpUseSMatrix InterpUsePortImpedance InterpUseFullBasis MagMinThreshold=0.01
